* Stage 34: candidate gain retune for 1-2 Vrms AUX, NE5532 proxy + single-ended power stage
* Screening only: generic NE5532-like opamp with 1.5 V output headroom; behavioral IR2110 and simplified IRFB7545 VDMOS.
.param Pvol=10k x=1 r={x**2.3} Ppot=100k bp=0.5 tp=0.5 deadcap=470p Fsig=1k Rs=1k Vbus=24
Vmid mid 0 6
V5 v5 0 5
V12 opvcc 0 12
Vbusraw braw 0 {Vbus}
Rbus braw bus 50m
Cbus bus 0 4700u Rser=0.05
VccDrv vcc 0 12
* AUX input sweep: 0.5, 1, 2, 2.5 Vrms
Vin src 0 SINE(0 {Vinpk} {Fsig})
Rsource src s2 100
Cin s2 inp 2.2u
Rb inp mid 47k
* NE5532 section 1: input buffer, generic 10 MHz GBW / output clamp
XBUF inp bufout bufout opvcc 0 NE5532_SCREEN
* Baxandall bass/treble, centred for flat response
R1 bufout a 33k
R2 b toneout 33k
Rpa a w {Ppot*bp}
Rpb w b {Ppot*(1-bp)}
C1 a w 47n
C2 b w 47n
C3 bufout t1 3.3n
C4 t2 toneout 3.3n
Rta t1 tw {Ppot*tp}
Rtb tw t2 {Ppot*(1-tp)}
R5 tw w 8.2k
XTON mid w toneout opvcc 0 NE5532_SCREEN
Bbufaudio buf_audio 0 V=V(bufout)-6
Btoneaudio tone_audio 0 V=V(toneout)-6
* Stage 4 volume + 3.3k fixed input limiting resistor + comparator bias/attenuator
Rlimit toneout psrc {Rs}
Rup psrc wip {Pvol*(1-r)+1}
Rlo wip mid {Pvol*r+1}
Cc wip c 1u
Ratt c cmp 68k
Rh v5 cmp 200k
Rl cmp 0 200k
Ccmp cmp 0 10p
* Idealized 0.5-4.5V integrator triangle carrier
Rpull osc v5 1
Bctrl ctrl 0 V=5-V(tri)
Ssch osc 0 ctrl 0 SCHMITT
.model SCHMITT SW(Ron=1m Roff=1G Vt=2.5 Vh=2)
Rintegrator osc sum 10k
Cintegrator tri sum 208.333p
Bop tri 0 V=limit(1e6*(2.5-V(sum)),0,5)
.ic V(tri)=4.5 V(sum)=2.4999955 V(osc)=5 V(out)=12 V(spk)=0
Bcmp pwm 0 V=if(V(cmp)>V(tri),5,0)
Binv inv 0 V=if(delay(V(pwm),10n)>2.5,0,5)
* RC-diode deadtime network
Rhin pwm hin 1k
Chin hin 0 {deadcap}
Dhin hin pwm Dfast
Rlin inv lin 1k
Clin lin 0 {deadcap}
Dlin lin inv Dfast
.model Dfast D(Is=2.52n Rs=0.568 N=1.9 Cjo=4p M=0.03 Tt=4n)
* Behavioral IR2110 timing, 10-ohm gate resistors
BdrvH drvH sw V=V(vb,sw)*if(V(hin)>2.5,if(delay(V(hin),120n)>2.5,1,0),if(delay(V(hin),94n)>2.5,1,0))
BdrvL drvL 0 V=12*if(V(lin)>2.5,if(delay(V(lin),120n)>2.5,1,0),if(delay(V(lin),94n)>2.5,1,0))
Rgh drvH gh 10
Rgl drvL gl 10
CextraH gh sw 3.5n
CextraL gl 0 3.5n
Dboot vcc vb Dfast
Cboot vb sw 220n Rser=0.1
Mhi bus gh sw IRFB7545Model
Mlo sw gl 0 IRFB7545Model
.model IRFB7545Model VDMOS(Vto=2.9 Kp=100 Rd=2m Rs=2m Rg=2.3 Cgs=6.3n Cgdmin=200p Cgdmax=1.8n Cjo=1n Is=1e-12 BV=60)
* Single-ended LC output into a grounded 4-ohm load
Lout sw out 33u Rser=0.15
Cout out 0 1u Rser=0.05
Cblock out spk 6800u Rser=0.08 IC=12
Rload spk 0 4
Boverlap21 overlap21 0 V=if(V(gh,sw)>2.1 & V(gl)>2.1,1,0)
* Generic NE5532 proxy: Aol=100k, dominant pole gives approx 10 MHz GBW, clamp 1.5 V from each rail
.subckt NE5532_SCREEN inp inn out vcc vee
E1 n1 0 inp inn 100k
R1 n1 n2 1k
C1 n2 0 1.59u
B1 out 0 V=min(max(V(n2),V(vee)+1.5),V(vcc)-1.5)
.ends NE5532_SCREEN
.step param Vinpk list 0.707107 1.414214 2.828427 3.535534
.tran 0 6m 5m 100n
.meas TRAN InputRMS RMS V(src) FROM=5m TO=6m
.meas TRAN BufferAudioRMS RMS V(buf_audio) FROM=5m TO=6m
.meas TRAN ToneAudioRMS RMS V(tone_audio) FROM=5m TO=6m
.meas TRAN BufferMin MIN V(bufout) FROM=5m TO=6m
.meas TRAN BufferMax MAX V(bufout) FROM=5m TO=6m
.meas TRAN ToneMin MIN V(toneout) FROM=5m TO=6m
.meas TRAN ToneMax MAX V(toneout) FROM=5m TO=6m
.meas TRAN CmpMin MIN V(cmp) FROM=5m TO=6m
.meas TRAN CmpMax MAX V(cmp) FROM=5m TO=6m
.meas TRAN LoadRMS RMS V(spk) FROM=5m TO=6m
.meas TRAN LoadPower PARAM LoadRMS*LoadRMS/4
.meas TRAN LoadIrms RMS I(Rload) FROM=5m TO=6m
.meas TRAN LoadIpk MAX abs(I(Rload)) FROM=5m TO=6m
.meas TRAN InductorIpk MAX abs(I(Lout)) FROM=5m TO=6m
.meas TRAN OverlapMax MAX V(overlap21) FROM=5m TO=6m
.meas TRAN BootstrapMin MIN V(vb,sw) FROM=5m TO=6m
.meas TRAN BusVmin MIN V(bus) FROM=5m TO=6m
.meas TRAN BusVmax MAX V(bus) FROM=5m TO=6m
.save V(src) V(inp) V(bufout) V(buf_audio) V(toneout) V(tone_audio) V(cmp) V(tri) V(pwm) V(gh,sw) V(gl) V(vb,sw) V(sw) V(out) V(spk) V(bus) V(overlap21) I(Lout) I(Rload)
.end
