* Stage 32: 1 Vrms AUX input screen at maximum volume
* Physical output reference: half-bridge LC output has bus/2 DC; a polarized series capacitor feeds a grounded 4-ohm speaker.
* Simplified IRFB7545 VDMOS and behavioral IR2110; screening model only.
.param Pvol=10k x=1 r={x**2.3} deadcap=470p Fsig=1k Rs=2.7k Vbus=24 Vinpk=1.41421356
Vmid mid 0 6
V5 v5 0 5
Vbusraw braw 0 {Vbus}
Rbus braw bus 50m
Cbus bus 0 4700u Rser=0.05
Vcc vcc 0 12
Vin in mid SINE(0 {Vinpk} {Fsig})
Rinser in psrc {Rs}
Rup psrc wip {Pvol*(1-r)+1}
Rlo wip mid {Pvol*r+1}
Cc wip c 1u
Ratt c cmp 150k
Rh v5 cmp 200k
Rl cmp 0 200k
Ccmp cmp 0 10p
* Idealized integrator oscillator: 0.5-4.5V ramp near 150kHz
Rpull osc v5 1
Bctrl ctrl 0 V=5-V(tri)
Ssch osc 0 ctrl 0 SCHMITT
.model SCHMITT SW(Ron=1m Roff=1G Vt=2.5 Vh=2)
Rintegrator osc sum 10k
Cintegrator tri sum 208.333p
Bop tri 0 V=limit(1e6*(2.5-V(sum)),0,5)
.ic V(tri)=4.5 V(sum)=2.4999955 V(osc)=5 V(out)=12 V(spk)=0
Bcmp pwm 0 V=if(V(cmp)>V(tri),5,0)
Binv inv 0 V=if(delay(V(pwm),10n)>2.5,0,5)
Rhin pwm hin 1k
Chin hin 0 {deadcap}
Dhin hin pwm Dfast
Rlin inv lin 1k
Clin lin 0 {deadcap}
Dlin lin inv Dfast
.model Dfast D(Is=2.52n Rs=0.568 N=1.9 Cjo=4p M=0.03 Tt=4n)
* Behavioral IR2110 timing (typical delays only); 10-ohm gate resistors
BdrvH drvH sw V=V(vb,sw)*if(V(hin)>2.5,if(delay(V(hin),120n)>2.5,1,0),if(delay(V(hin),94n)>2.5,1,0))
BdrvL drvL 0 V=12*if(V(lin)>2.5,if(delay(V(lin),120n)>2.5,1,0),if(delay(V(lin),94n)>2.5,1,0))
Rgh drvH gh 10
Rgl drvL gl 10
CextraH gh sw 3.5n
CextraL gl 0 3.5n
Dboot vcc vb Dfast
Cboot vb sw 220n Rser=0.1
Mhi bus gh sw IRFB7545Model
Mlo sw gl 0 IRFB7545Model
.model IRFB7545Model VDMOS(Vto=2.9 Kp=100 Rd=2m Rs=2m Rg=2.3 Cgs=6.3n Cgdmin=200p Cgdmax=1.8n Cjo=1n Is=1e-12 BV=60)
Lout sw out 33u Rser=0.15
Cout out 0 1u Rser=0.05
Cblock out spk 6800u Rser=0.08 IC=12
Rload spk 0 4
Boverlap21 overlap21 0 V=if(V(gh,sw)>2.1 & V(gl)>2.1,1,0)
.tran 0 6m 5m 100n
.meas TRAN LoadRMS RMS V(spk) FROM=5m TO=6m
.meas TRAN LoadPower PARAM LoadRMS*LoadRMS/4
.meas TRAN LoadIrms RMS I(Rload) FROM=5m TO=6m
.meas TRAN LoadIpk MAX abs(I(Rload)) FROM=5m TO=6m
.meas TRAN InductorIpk MAX abs(I(Lout)) FROM=5m TO=6m
.meas TRAN BusVmin MIN V(bus) FROM=5m TO=6m
.meas TRAN BusVmax MAX V(bus) FROM=5m TO=6m
.meas TRAN OverlapMax MAX V(overlap21) FROM=5m TO=6m
.meas TRAN BootstrapMin MIN V(vb,sw) FROM=5m TO=6m
.save V(cmp) V(tri) V(pwm) V(gh,sw) V(gl) V(vb,sw) V(sw) V(out) V(spk) V(bus) I(Rbus) I(Lout) I(Rload) V(overlap21)
.end
