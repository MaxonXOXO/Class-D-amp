* PCB1 stage 4: volume + coupling + comparator bias
.param Pvol=10k x=0.5
.param r={x**2.3}
Vm mid 0 6
V5 v5 0 5
Vin in mid AC 1
Rup in wip {Pvol*(1-r)+1}
Rlo wip mid {Pvol*r+1}
Cc wip c 1u
Rh v5 c 200k
Rl c 0 200k
Cl c 0 10p
.step param x list 0.2 0.5 0.8 1.0
.ac dec 100 1 1meg
.end
